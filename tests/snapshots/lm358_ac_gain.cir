* eda_agent testbench A1 (ac), attempt default
* generated by eda_agent.sim.testbench - do not edit by hand
.include models/lm358.lib
* net +5V = node p5V
* net GND = node 0
* net IN = node IN
* net FB = node FB
* net OUT = node OUT
* net BUF = node BUF
VI_U1_1 OUT U1_1 DC 0
VI_U1_2 FB U1_2 DC 0
VI_U1_3 IN U1_3 DC 0
VI_U1_4 0 U1_4 DC 0
VI_U1_5 0 U1_5 DC 0
VI_U1_6 BUF U1_6 DC 0
VI_U1_7 BUF U1_7 DC 0
VI_U1_8 p5V U1_8 DC 0
XU1 U1_1 U1_2 U1_3 U1_4 U1_5 U1_6 U1_7 U1_8 LM358_DUAL
VI_R1_1 OUT R1_1 DC 0
VI_R1_2 FB R1_2 DC 0
R1 R1_1 R1_2 10000
VI_R2_1 FB R2_1 DC 0
VI_R2_2 0 R2_2 DC 0
R2 R2_1 R2_2 1000
VI_R3_1 IN R3_1 DC 0
VI_R3_2 0 R3_2 DC 0
R3 R3_1 R3_2 100000
VI_C1_1 p5V C1_1 DC 0
VI_C1_2 0 C1_2 DC 0
C1 C1_1 C1_2 1e-07
VS_p5V x_p5V 0 DC 5
VX_p5V x_p5V p5V DC 0
VS_IN x_IN 0 DC 0.2 AC 1
VX_IN x_IN IN DC 0
.ac dec 50 10 10000000
.meas ac m_a1_out FIND vdb(OUT) AT=1000
.meas ac m_a1_ref FIND vdb(IN) AT=1000
.end
