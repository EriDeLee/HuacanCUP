* eda_agent testbench A2 (op), attempt default
* generated by eda_agent.sim.testbench - do not edit by hand
* net VIN = node VIN
* net MID = node MID
* net GND = node 0
VI_R1_1 VIN R1_1 DC 0
VI_R1_2 MID R1_2 DC 0
R1 R1_1 R1_2 30000
VI_R2_1 MID R2_1 DC 0
VI_R2_2 0 R2_2 DC 0
R2 R2_1 R2_2 10000
VS_VIN x_VIN 0 DC 12
VX_VIN x_VIN VIN DC 0
.op
.end
