* eda_agent testbench A2 (transient), attempt default
* generated by eda_agent.sim.testbench - do not edit by hand
.include models/irlz44n.lib
.include models/lm393.lib
* net VBAT = node VBAT
* net LOAD_N = node LOAD_N
* net ISENSE = node ISENSE
* net GND = node 0
* net +5V = node p5V
* net ISENSE_F = node ISENSE_F
* net VREF = node VREF
* net GATE = node GATE
VI_Q1_2 LOAD_N Q1_2 DC 0
VI_Q1_1 GATE Q1_1 DC 0
VI_Q1_3 ISENSE Q1_3 DC 0
MQ1 Q1_2 Q1_1 Q1_3 IRLZ44N
VI_R1_1 ISENSE R1_1 DC 0
VI_R1_2 0 R1_2 DC 0
R1 R1_1 R1_2 0.01
VI_U1_1 GATE U1_1 DC 0
VI_U1_2 ISENSE_F U1_2 DC 0
VI_U1_3 VREF U1_3 DC 0
VI_U1_4 0 U1_4 DC 0
VI_U1_5 0 U1_5 DC 0
VI_U1_6 p5V U1_6 DC 0
VI_U1_8 p5V U1_8 DC 0
XU1 U1_1 U1_2 U1_3 U1_4 U1_5 U1_6 nc_U1_7 U1_8 LM393_DUAL
VI_R2_1 ISENSE R2_1 DC 0
VI_R2_2 ISENSE_F R2_2 DC 0
R2 R2_1 R2_2 1000
VI_C2_1 ISENSE_F C2_1 DC 0
VI_C2_2 0 C2_2 DC 0
C2 C2_1 C2_2 1e-07
VI_R4_1 p5V R4_1 DC 0
VI_R4_2 VREF R4_2 DC 0
R4 R4_1 R4_2 100000
VI_R5_1 VREF R5_1 DC 0
VI_R5_2 0 R5_2 DC 0
R5 R5_1 R5_2 1000
VI_R6_1 p5V R6_1 DC 0
VI_R6_2 GATE R6_2 DC 0
R6 R6_1 R6_2 10000
VI_R7_1 VREF R7_1 DC 0
VI_R7_2 GATE R7_2 DC 0
R7 R7_1 R7_2 1000000
VI_C3_1 p5V C3_1 DC 0
VI_C3_2 0 C3_2 DC 0
C3 C3_1 C3_2 1e-07
VS_VBAT x_VBAT 0 DC 12
VX_VBAT x_VBAT VBAT DC 0
VS_p5V x_p5V 0 DC 5
VX_p5V x_p5V p5V DC 0
VL_load VBAT load_mid DC 0
BL_load load_mid LOAD_N I = 2*0.5*(1+tanh((V(load_mid,LOAD_N)-1)/0.1))
.tran 5e-06 0.005 0 5e-06
.meas tran m_a2 MIN i(VL_load) FROM=0.0005
.end
