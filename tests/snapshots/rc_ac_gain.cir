* eda_agent testbench A2 (ac), attempt default
* generated by eda_agent.sim.testbench - do not edit by hand
* net IN = node IN
* net OUT = node OUT
* net GND = node 0
VI_R1_1 IN R1_1 DC 0
VI_R1_2 OUT R1_2 DC 0
R1 R1_1 R1_2 10000
VI_C1_1 OUT C1_1 DC 0
VI_C1_2 0 C1_2 DC 0
C1 C1_1 C1_2 1e-08
VS_IN x_IN 0 DC 0 AC 1
VX_IN x_IN IN DC 0
.ac dec 50 10 100000
.meas ac m_a2_out FIND vdb(OUT) AT=10000
.meas ac m_a2_ref FIND vdb(IN) AT=10000
.end
