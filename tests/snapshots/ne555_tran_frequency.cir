* eda_agent testbench A1 (transient), attempt default
* generated by eda_agent.sim.testbench - do not edit by hand
.include models/led_red_generic.lib
.include models/ua555.lib
* net +5V = node p5V
* net GND = node 0
* net DIS = node DIS
* net THR = node THR
* net CTRL = node CTRL
* net OUT = node OUT
* net LED_A = node LED_A
VI_U1_1 0 U1_1 DC 0
VI_U1_2 THR U1_2 DC 0
VI_U1_3 OUT U1_3 DC 0
VI_U1_4 p5V U1_4 DC 0
VI_U1_5 CTRL U1_5 DC 0
VI_U1_6 THR U1_6 DC 0
VI_U1_7 DIS U1_7 DC 0
VI_U1_8 p5V U1_8 DC 0
XU1 U1_1 U1_2 U1_3 U1_4 U1_5 U1_6 U1_7 U1_8 NE555
VI_R1_1 p5V R1_1 DC 0
VI_R1_2 DIS R1_2 DC 0
R1 R1_1 R1_2 1000
VI_R2_1 DIS R2_1 DC 0
VI_R2_2 THR R2_2 DC 0
R2 R2_1 R2_2 10000
VI_C1_1 THR C1_1 DC 0
VI_C1_2 0 C1_2 DC 0
C1 C1_1 C1_2 1e-05
VI_C2_1 CTRL C2_1 DC 0
VI_C2_2 0 C2_2 DC 0
C2 C2_1 C2_2 1e-08
VI_C3_1 p5V C3_1 DC 0
VI_C3_2 0 C3_2 DC 0
C3 C3_1 C3_2 1e-07
VI_R3_1 OUT R3_1 DC 0
VI_R3_2 LED_A R3_2 DC 0
R3 R3_1 R3_2 330
VI_D1_2 LED_A D1_2 DC 0
VI_D1_1 0 D1_1 DC 0
D1 D1_2 D1_1 LED_RED_GENERIC
VS_p5V x_p5V 0 DC 5
VX_p5V x_p5V p5V DC 0
.tran 0.001 1.6 0 0.001
.meas tran m_a1 TRIG v(OUT) VAL=2.5 RISE=1 TD=0.5 TARG v(OUT) VAL=2.5 RISE=4 TD=0.5
.end
